* WLED Wiring regression reference: PSU -> DCDC -> resistor
* 12 V input source, ideal 5 V DCDC output, 90 % efficiency, 10 ohm load.

.param Vin=12
.param Vout=5
.param Eff=0.9
.param Rload=10
.param Rwire=1.7241e-6

V_PSU psu_p 0 {Vin}
R_IN psu_p dcdc_in {Rwire}
R_IN_GND 0 dcdc_gnd_in {Rwire}

V_DCDC_OUT dcdc_out dcdc_gnd_out {Vout}
B_DCDC_IN dcdc_in dcdc_gnd_in I={V(dcdc_out,dcdc_gnd_out)*abs(I(V_DCDC_OUT))/(Eff*max(V(dcdc_in,dcdc_gnd_in),0.5))}
R_GND_BRIDGE dcdc_gnd_in dcdc_gnd_out 1u

R_OUT dcdc_out load_p {Rwire}
R_OUT_GND load_n dcdc_gnd_out {Rwire}
R_LOAD load_p load_n {Rload}

.op
.meas op v_psu_out FIND V(psu_p)
.meas op v_dcdc_in FIND V(dcdc_in)
.meas op v_dcdc_out FIND V(dcdc_out,dcdc_gnd_out)
.meas op v_load_p FIND V(load_p)
.meas op i_dcdc_in PARAM abs(I(B_DCDC_IN))
.meas op i_load PARAM abs(I(R_LOAD))
.end
